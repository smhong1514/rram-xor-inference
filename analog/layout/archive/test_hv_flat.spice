* NGSPICE file created from test_hv_flat.ext - technology: sky130B

.subckt test_hv_flat
X0 a_36_88# a_94_0# a_36_88# VSUBS sky130_fd_pr__nfet_g5v0d10v5 ad=0.58 pd=4.58 as=1.16 ps=9.16 w=2 l=0.5
.ends
