* NGSPICE file created from test_nfet_w200_flat.ext - technology: sky130B

.subckt test_nfet_w200_flat
X0 dev_nfet_w200_0.D dev_nfet_w200_0.G dev_nfet_w200_0.S VSUBS sky130_fd_pr__nfet_01v8 ad=0.58 pd=4.58 as=0.58 ps=4.58 w=2 l=0.15
.ends
