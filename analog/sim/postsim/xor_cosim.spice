* ============================================================
* 2-Array XOR Inference Mixed-Signal Co-Simulation
* d_cosim: xor_controller + input_encoder + sae_control
* Analog: 2x RRAM 4x4 + 8x WL Driver + 3x SA + 8x BL WD
*
* XOR(A,B) = AND( OR(A,B), NAND(A,B) )
*   Phase 0: Array 1 → SA1(OR), SA2(NAND)
*   Phase 1: Array 2 → SA3(AND = XOR result)
*
* Test: all 4 XOR combinations
*   t=100ns  A=0,B=0 → expect 0
*   t=2000ns A=0,B=1 → expect 1
*   t=4000ns A=1,B=0 → expect 1
*   t=6000ns A=1,B=1 → expect 0
* ============================================================
.title XOR_COSIM

** --------------------------------------------------------
** Sky130 PDK device models
** --------------------------------------------------------
.lib $PDK_ROOT/sky130B/libs.tech/ngspice/sky130.lib.spice tt

** --------------------------------------------------------
** RRAM cell subcircuit (OSDI compact model)
** --------------------------------------------------------
.subckt sky130_fd_pr_reram__reram_cell TE BE Tfilament_0=3.5e-9
.model rram_local sky130_fd_pr_reram__reram_cell
+ Tfilament_0 = Tfilament_0
+ area_ox = 0.1024e-12
+ Tox = 5.0e-9
+ Tfilament_max = 4.9e-9
+ Tfilament_min = 3.4e-9
+ Eact_generation = 1.501
+ Eact_recombination = 1.500
+ I_k1 = 6.140e-5
+ Tfilament_ref = 4.7249e-9
+ V_ref = 0.430
+ velocity_k1 = 150
+ gamma_k0 = 16.5
+ gamma_k1 = -1.25
+ Temperature_0 = 300
+ C_thermal = 3.1825e-16
+ tau_thermal = 0.23e-9
+ t_step = 1.0e-9
N1 TE BE rram_local
.ends sky130_fd_pr_reram__reram_cell

** --------------------------------------------------------
** WL Driver (layout-extracted, 8 transistors)
** --------------------------------------------------------
.subckt wl_driver IN OUT VDD VWL VSS
X0 OUT a_423_138# VSS VSS sky130_fd_pr__nfet_g5v0d10v5 ad=0.58 pd=4.58 as=0.58 ps=4.58 w=2 l=0.5
X1 a_423_138# IN VSS VSS sky130_fd_pr__nfet_g5v0d10v5 ad=0.58 pd=4.58 as=0.58 ps=4.58 w=2 l=0.5
X2 a_342_589# a_57_213# VSS VSS sky130_fd_pr__nfet_g5v0d10v5 ad=0.58 pd=4.58 as=0.58 ps=4.58 w=2 l=0.5
X3 a_57_213# IN VDD VDD sky130_fd_pr__pfet_01v8 ad=0.27 pd=2.54 as=0.27 ps=2.54 w=1 l=0.15
X4 OUT a_423_138# VWL VWL sky130_fd_pr__pfet_g5v0d10v5 ad=1.16 pd=8.58 as=1.16 ps=8.58 w=4 l=0.5
X5 a_57_213# IN VSS VSS sky130_fd_pr__nfet_01v8 ad=0.135 pd=1.54 as=0.135 ps=1.54 w=0.5 l=0.15
X6 a_423_138# a_342_589# VWL VWL sky130_fd_pr__pfet_g5v0d10v5 ad=0.29 pd=2.58 as=0.29 ps=2.58 w=1 l=0.5
X7 a_342_589# a_423_138# VWL VWL sky130_fd_pr__pfet_g5v0d10v5 ad=0.29 pd=2.58 as=0.29 ps=2.58 w=1 l=0.5
.ends wl_driver

** --------------------------------------------------------
** Sense Amplifier (layout-extracted, StrongARM, 10 transistors)
** Differential: INP vs INN → Q, QB
** --------------------------------------------------------
.subckt sense_amp SAE INP INN Q QB VDD VSS
X0 Q SAE VDD VDD sky130_fd_pr__pfet_01v8 ad=0.135 pd=1.54 as=0.135 ps=1.54 w=0.5 l=0.15
X1 QB Q VDD VDD sky130_fd_pr__pfet_01v8 ad=0.27 pd=2.54 as=0.27 ps=2.54 w=1 l=0.15
X2 a_15_458# INP a_15_128# VSS sky130_fd_pr__nfet_01v8 ad=0.54 pd=4.54 as=0.54 ps=4.54 w=2 l=0.15
X3 QB SAE Q VDD sky130_fd_pr__pfet_01v8 ad=0.135 pd=1.54 as=0.135 ps=1.54 w=0.5 l=0.15
X4 QB SAE VDD VDD sky130_fd_pr__pfet_01v8 ad=0.135 pd=1.54 as=0.135 ps=1.54 w=0.5 l=0.15
X5 Q QB a_15_458# VSS sky130_fd_pr__nfet_01v8 ad=0.27 pd=2.54 as=0.27 ps=2.54 w=1 l=0.15
X6 a_15_128# SAE VSS VSS sky130_fd_pr__nfet_01v8 ad=0.54 pd=4.54 as=0.54 ps=4.54 w=2 l=0.15
X7 a_273_458# INN a_15_128# VSS sky130_fd_pr__nfet_01v8 ad=0.54 pd=4.54 as=0.54 ps=4.54 w=2 l=0.15
X8 Q QB VDD VDD sky130_fd_pr__pfet_01v8 ad=0.27 pd=2.54 as=0.27 ps=2.54 w=1 l=0.15
X9 QB Q a_273_458# VSS sky130_fd_pr__nfet_01v8 ad=0.27 pd=2.54 as=0.27 ps=2.54 w=1 l=0.15
.ends sense_amp

** --------------------------------------------------------
** BL Write Driver (layout-extracted, tri-state, 8 transistors)
** --------------------------------------------------------
.subckt bl_write_driver EN DATA BL VDD VSS
X0 a_186_658# a_57_128# VDD VDD sky130_fd_pr__pfet_01v8 ad=1.08 pd=8.54 as=1.08 ps=8.54 w=4 l=0.15
X1 BL a_291_609# a_186_658# VDD sky130_fd_pr__pfet_01v8 ad=1.08 pd=8.54 as=1.08 ps=8.54 w=4 l=0.15
X2 a_57_128# EN VSS VSS sky130_fd_pr__nfet_01v8 ad=0.135 pd=1.54 as=0.135 ps=1.54 w=0.5 l=0.15
X3 a_291_609# DATA VSS VSS sky130_fd_pr__nfet_01v8 ad=0.135 pd=1.54 as=0.135 ps=1.54 w=0.5 l=0.15
X4 a_57_128# EN VDD VDD sky130_fd_pr__pfet_01v8 ad=0.135 pd=1.54 as=0.135 ps=1.54 w=0.5 l=0.15
X5 a_186_128# EN VSS VSS sky130_fd_pr__nfet_01v8 ad=1.08 pd=8.54 as=1.08 ps=8.54 w=4 l=0.15
X6 BL a_291_609# a_186_128# VSS sky130_fd_pr__nfet_01v8 ad=1.08 pd=8.54 as=1.08 ps=8.54 w=4 l=0.15
X7 a_291_609# DATA VDD VDD sky130_fd_pr__pfet_01v8 ad=0.135 pd=1.54 as=0.135 ps=1.54 w=0.5 l=0.15
.ends bl_write_driver

** ============================================================
** RRAM Array 1: OR + NAND weights
** ============================================================
** SL = {1, 1, B, A} → Row0=A, Row1=B, Row2=bias, Row3=zero
**
** Weight matrix (Tfilament_0 values):
**        BL[0]    BL[1]    BL[2]    BL[3]
**        OR(+)    OR(-)    NAND(+)  NAND(-)
** Row 0: LRS      HRS      HRS      LRS       ← A
** Row 1: LRS      HRS      HRS      LRS       ← B
** Row 2: HRS      mLRS     sLRS     HRS       ← bias
** Row 3: HRS      HRS      HRS      HRS       ← zero
** ============================================================
.subckt rram_array_1 BL0 BL1 BL2 BL3 WL0 WL1 WL2 WL3 SL0 SL1 SL2 SL3 GND
* Row 0 (SL0 = input A)
XR00 BL0 n00 sky130_fd_pr_reram__reram_cell Tfilament_0=4.5e-9
XM00 n00 WL0 SL0 GND sky130_fd_pr__nfet_g5v0d10v5 L=0.5 W=1.5 nf=1 ad=0.435 as=0.435 pd=3.58 ps=3.58
XR01 BL1 n01 sky130_fd_pr_reram__reram_cell Tfilament_0=3.5e-9
XM01 n01 WL0 SL0 GND sky130_fd_pr__nfet_g5v0d10v5 L=0.5 W=1.5 nf=1 ad=0.435 as=0.435 pd=3.58 ps=3.58
XR02 BL2 n02 sky130_fd_pr_reram__reram_cell Tfilament_0=3.5e-9
XM02 n02 WL0 SL0 GND sky130_fd_pr__nfet_g5v0d10v5 L=0.5 W=1.5 nf=1 ad=0.435 as=0.435 pd=3.58 ps=3.58
XR03 BL3 n03 sky130_fd_pr_reram__reram_cell Tfilament_0=4.5e-9
XM03 n03 WL0 SL0 GND sky130_fd_pr__nfet_g5v0d10v5 L=0.5 W=1.5 nf=1 ad=0.435 as=0.435 pd=3.58 ps=3.58
* Row 1 (SL1 = input B)
XR10 BL0 n10 sky130_fd_pr_reram__reram_cell Tfilament_0=4.5e-9
XM10 n10 WL1 SL1 GND sky130_fd_pr__nfet_g5v0d10v5 L=0.5 W=1.5 nf=1 ad=0.435 as=0.435 pd=3.58 ps=3.58
XR11 BL1 n11 sky130_fd_pr_reram__reram_cell Tfilament_0=3.5e-9
XM11 n11 WL1 SL1 GND sky130_fd_pr__nfet_g5v0d10v5 L=0.5 W=1.5 nf=1 ad=0.435 as=0.435 pd=3.58 ps=3.58
XR12 BL2 n12 sky130_fd_pr_reram__reram_cell Tfilament_0=3.5e-9
XM12 n12 WL1 SL1 GND sky130_fd_pr__nfet_g5v0d10v5 L=0.5 W=1.5 nf=1 ad=0.435 as=0.435 pd=3.58 ps=3.58
XR13 BL3 n13 sky130_fd_pr_reram__reram_cell Tfilament_0=4.5e-9
XM13 n13 WL1 SL1 GND sky130_fd_pr__nfet_g5v0d10v5 L=0.5 W=1.5 nf=1 ad=0.435 as=0.435 pd=3.58 ps=3.58
* Row 2 (SL2 = bias, always 1)
XR20 BL0 n20 sky130_fd_pr_reram__reram_cell Tfilament_0=3.5e-9
XM20 n20 WL2 SL2 GND sky130_fd_pr__nfet_g5v0d10v5 L=0.5 W=1.5 nf=1 ad=0.435 as=0.435 pd=3.58 ps=3.58
XR21 BL1 n21 sky130_fd_pr_reram__reram_cell Tfilament_0=4.0e-9
XM21 n21 WL2 SL2 GND sky130_fd_pr__nfet_g5v0d10v5 L=0.5 W=1.5 nf=1 ad=0.435 as=0.435 pd=3.58 ps=3.58
XR22 BL2 n22 sky130_fd_pr_reram__reram_cell Tfilament_0=4.6e-9
XM22 n22 WL2 SL2 GND sky130_fd_pr__nfet_g5v0d10v5 L=0.5 W=1.5 nf=1 ad=0.435 as=0.435 pd=3.58 ps=3.58
XR23 BL3 n23 sky130_fd_pr_reram__reram_cell Tfilament_0=3.5e-9
XM23 n23 WL2 SL2 GND sky130_fd_pr__nfet_g5v0d10v5 L=0.5 W=1.5 nf=1 ad=0.435 as=0.435 pd=3.58 ps=3.58
* Row 3 (SL3 = bias, always 1) — all HRS (zero weight)
XR30 BL0 n30 sky130_fd_pr_reram__reram_cell Tfilament_0=3.5e-9
XM30 n30 WL3 SL3 GND sky130_fd_pr__nfet_g5v0d10v5 L=0.5 W=1.5 nf=1 ad=0.435 as=0.435 pd=3.58 ps=3.58
XR31 BL1 n31 sky130_fd_pr_reram__reram_cell Tfilament_0=3.5e-9
XM31 n31 WL3 SL3 GND sky130_fd_pr__nfet_g5v0d10v5 L=0.5 W=1.5 nf=1 ad=0.435 as=0.435 pd=3.58 ps=3.58
XR32 BL2 n32 sky130_fd_pr_reram__reram_cell Tfilament_0=3.5e-9
XM32 n32 WL3 SL3 GND sky130_fd_pr__nfet_g5v0d10v5 L=0.5 W=1.5 nf=1 ad=0.435 as=0.435 pd=3.58 ps=3.58
XR33 BL3 n33 sky130_fd_pr_reram__reram_cell Tfilament_0=3.5e-9
XM33 n33 WL3 SL3 GND sky130_fd_pr__nfet_g5v0d10v5 L=0.5 W=1.5 nf=1 ad=0.435 as=0.435 pd=3.58 ps=3.58
.ends rram_array_1

** ============================================================
** RRAM Array 2: AND weights
** ============================================================
** SL = {1, 1, h2, h1}
**        BL[0]    BL[1]    BL[2]    BL[3]
**        AND(+)   AND(-)   (unused) (unused)
** Row 0: LRS      HRS      HRS      HRS       ← h1
** Row 1: LRS      HRS      HRS      HRS       ← h2
** Row 2: HRS      sLRS2    HRS      HRS       ← bias (Tf=4.8, stronger than Array1)
** Row 3: HRS      HRS      HRS      HRS       ← zero
** ============================================================
.subckt rram_array_2 BL0 BL1 BL2 BL3 WL0 WL1 WL2 WL3 SL0 SL1 SL2 SL3 GND
* Row 0 (SL0 = h1)
XR00 BL0 n00 sky130_fd_pr_reram__reram_cell Tfilament_0=4.5e-9
XM00 n00 WL0 SL0 GND sky130_fd_pr__nfet_g5v0d10v5 L=0.5 W=1.5 nf=1 ad=0.435 as=0.435 pd=3.58 ps=3.58
XR01 BL1 n01 sky130_fd_pr_reram__reram_cell Tfilament_0=3.5e-9
XM01 n01 WL0 SL0 GND sky130_fd_pr__nfet_g5v0d10v5 L=0.5 W=1.5 nf=1 ad=0.435 as=0.435 pd=3.58 ps=3.58
XR02 BL2 n02 sky130_fd_pr_reram__reram_cell Tfilament_0=3.5e-9
XM02 n02 WL0 SL0 GND sky130_fd_pr__nfet_g5v0d10v5 L=0.5 W=1.5 nf=1 ad=0.435 as=0.435 pd=3.58 ps=3.58
XR03 BL3 n03 sky130_fd_pr_reram__reram_cell Tfilament_0=3.5e-9
XM03 n03 WL0 SL0 GND sky130_fd_pr__nfet_g5v0d10v5 L=0.5 W=1.5 nf=1 ad=0.435 as=0.435 pd=3.58 ps=3.58
* Row 1 (SL1 = h2)
XR10 BL0 n10 sky130_fd_pr_reram__reram_cell Tfilament_0=4.5e-9
XM10 n10 WL1 SL1 GND sky130_fd_pr__nfet_g5v0d10v5 L=0.5 W=1.5 nf=1 ad=0.435 as=0.435 pd=3.58 ps=3.58
XR11 BL1 n11 sky130_fd_pr_reram__reram_cell Tfilament_0=3.5e-9
XM11 n11 WL1 SL1 GND sky130_fd_pr__nfet_g5v0d10v5 L=0.5 W=1.5 nf=1 ad=0.435 as=0.435 pd=3.58 ps=3.58
XR12 BL2 n12 sky130_fd_pr_reram__reram_cell Tfilament_0=3.5e-9
XM12 n12 WL1 SL1 GND sky130_fd_pr__nfet_g5v0d10v5 L=0.5 W=1.5 nf=1 ad=0.435 as=0.435 pd=3.58 ps=3.58
XR13 BL3 n13 sky130_fd_pr_reram__reram_cell Tfilament_0=3.5e-9
XM13 n13 WL1 SL1 GND sky130_fd_pr__nfet_g5v0d10v5 L=0.5 W=1.5 nf=1 ad=0.435 as=0.435 pd=3.58 ps=3.58
* Row 2 (SL2 = bias, always 1)
XR20 BL0 n20 sky130_fd_pr_reram__reram_cell Tfilament_0=3.5e-9
XM20 n20 WL2 SL2 GND sky130_fd_pr__nfet_g5v0d10v5 L=0.5 W=1.5 nf=1 ad=0.435 as=0.435 pd=3.58 ps=3.58
XR21 BL1 n21 sky130_fd_pr_reram__reram_cell Tfilament_0=4.7e-9
XM21 n21 WL2 SL2 GND sky130_fd_pr__nfet_g5v0d10v5 L=0.5 W=1.5 nf=1 ad=0.435 as=0.435 pd=3.58 ps=3.58
XR22 BL2 n22 sky130_fd_pr_reram__reram_cell Tfilament_0=3.5e-9
XM22 n22 WL2 SL2 GND sky130_fd_pr__nfet_g5v0d10v5 L=0.5 W=1.5 nf=1 ad=0.435 as=0.435 pd=3.58 ps=3.58
XR23 BL3 n23 sky130_fd_pr_reram__reram_cell Tfilament_0=3.5e-9
XM23 n23 WL2 SL2 GND sky130_fd_pr__nfet_g5v0d10v5 L=0.5 W=1.5 nf=1 ad=0.435 as=0.435 pd=3.58 ps=3.58
* Row 3 (SL3 = bias, always 1) — all HRS
XR30 BL0 n30 sky130_fd_pr_reram__reram_cell Tfilament_0=3.5e-9
XM30 n30 WL3 SL3 GND sky130_fd_pr__nfet_g5v0d10v5 L=0.5 W=1.5 nf=1 ad=0.435 as=0.435 pd=3.58 ps=3.58
XR31 BL1 n31 sky130_fd_pr_reram__reram_cell Tfilament_0=3.5e-9
XM31 n31 WL3 SL3 GND sky130_fd_pr__nfet_g5v0d10v5 L=0.5 W=1.5 nf=1 ad=0.435 as=0.435 pd=3.58 ps=3.58
XR32 BL2 n32 sky130_fd_pr_reram__reram_cell Tfilament_0=3.5e-9
XM32 n32 WL3 SL3 GND sky130_fd_pr__nfet_g5v0d10v5 L=0.5 W=1.5 nf=1 ad=0.435 as=0.435 pd=3.58 ps=3.58
XR33 BL3 n33 sky130_fd_pr_reram__reram_cell Tfilament_0=3.5e-9
XM33 n33 WL3 SL3 GND sky130_fd_pr__nfet_g5v0d10v5 L=0.5 W=1.5 nf=1 ad=0.435 as=0.435 pd=3.58 ps=3.58
.ends rram_array_2

** ========================================================
** SIMULATION OPTIONS (convergence)
** ========================================================
.options reltol=5e-3
.options abstol=1e-10
.options vntol=1e-5
.options gmin=1e-12
.options method=gear

** ========================================================
** POWER SUPPLIES
** ========================================================
VDD  vdd     0 DC 1.8
VWLP vwl_pwr 0 DC 3.3

** ========================================================
** DIGITAL CLOCK (200MHz — faster sensing for co-sim)
** ========================================================
A_clk 0 clk_d clkmodel
.model clkmodel d_osc (cntl_array=[-1 1] freq_array=[200Meg 200Meg])

** ========================================================
** COMMAND STIMULUS
** ========================================================

* Reset: active-low, deassert at 50ns
V_rst rst_a 0 PWL(0 0 49n 0 50n 1.8)

* Start pulse: at 100ns, 2000ns, 4000ns, 6000ns
V_start start_a 0 PWL(0 0
+   99n 0 100n 1.8 120n 1.8 121n 0
+   1999n 0 2000n 1.8 2020n 1.8 2021n 0
+   3999n 0 4000n 1.8 4020n 1.8 4021n 0
+   5999n 0 6000n 1.8 6020n 1.8 6021n 0)

* Input A: 0, 0, 1, 1
V_ia ia_a 0 PWL(0 0 3999n 0 4000n 1.8)

* Input B: 0, 1, 0, 1
V_ib ib_a 0 PWL(0 0 1999n 0 2000n 1.8 2021n 1.8 2022n 0
+   3999n 0 4000n 0 5999n 0 6000n 1.8)

** ========================================================
** ADC BRIDGES: Analog → Digital
** ========================================================
.model adc1 adc_bridge (in_low=0.6 in_high=1.2 rise_delay=0.1n fall_delay=0.1n)

* Command inputs
A_adc_cmd [rst_a start_a ia_a ib_a]
+         [rst_d start_d ia_d ib_d]
+         adc1

* SA feedback (CLOSED LOOP): sa1_q, sa2_q, sa3_q → digital
A_adc_sa [sa1_q_a sa2_q_a sa3_q_a]
+        [sa1_d sa2_d sa3_d]
+        adc1

** ========================================================
** d_cosim XOR CONTROLLER (Verilator)
** ========================================================
* Inputs (8): clk, rst_n, start, input_a, input_b, sa1_q, sa2_q, sa3_q
* Outputs (19): ready, result_valid, xor_result,
*               wl_en[3:0], phase, sae,
*               sl_data_1[3:0], sl_data_2[3:0]
A_ctrl [clk_d rst_d start_d ia_d ib_d sa1_d sa2_d sa3_d]
+      [rdy_d rv_d xr_d
+       wl3_d wl2_d wl1_d wl0_d
+       phase_d sae_d
+       sl1_3_d sl1_2_d sl1_1_d sl1_0_d
+       sl2_3_d sl2_2_d sl2_1_d sl2_0_d]
+      null cosim_xor
.model cosim_xor d_cosim (simulation="./verilog/xor_cosim_top.so" delay=1n)

** ========================================================
** DAC BRIDGES: Digital → Analog
** ========================================================
.model dac1 dac_bridge (out_low=0 out_high=1.8 out_undef=0.9
+                       t_rise=0.5n t_fall=0.5n)

* Status signals
A_dac_status [rdy_d rv_d xr_d]
+            [rdy_a rv_a xr_a]
+            dac1

* WL enable (shared: drives both arrays)
A_dac_wl [wl3_d wl2_d wl1_d wl0_d]
+        [wl_in3 wl_in2 wl_in1 wl_in0]
+        dac1

* Phase and SAE
A_dac_ctrl [phase_d sae_d]
+          [phase_a sae_a]
+          dac1

* SL data for Array 1
A_dac_sl1 [sl1_3_d sl1_2_d sl1_1_d sl1_0_d]
+         [sl1_en3 sl1_en2 sl1_en1 sl1_en0]
+         dac1

* SL data for Array 2
A_dac_sl2 [sl2_3_d sl2_2_d sl2_1_d sl2_0_d]
+         [sl2_en3 sl2_en2 sl2_en1 sl2_en0]
+         dac1

** ========================================================
** PER-ARRAY BL PRECHARGE CONTROL
** Array 1: precharge OFF during Phase 0 (wl_on AND NOT phase)
** Array 2: precharge OFF during Phase 1 (wl_on AND phase)
** Between phases, the inactive array stays precharged (BL=VDD)
** ========================================================
A_or_wl [wl3_d wl2_d wl1_d wl0_d] wl_on_d d_or_model
.model d_or_model d_or (rise_delay=0.1n fall_delay=0.1n input_load=1e-15)

* Invert phase for Array 1 gating
A_inv_phase phase_d nphase_d d_inv_model
.model d_inv_model d_inverter (rise_delay=0.1n fall_delay=0.1n input_load=1e-15)

* Array 1 precharge release = wl_on AND NOT phase (active during Phase 0)
A_prech1_gate [wl_on_d nphase_d] prech1_d d_and_model
.model d_and_model d_and (rise_delay=0.1n fall_delay=0.1n input_load=1e-15)
A_dac_prech1 [prech1_d] [prech1_a] dac1

* Array 2 precharge release = wl_on AND phase (active during Phase 1)
A_prech2_gate [wl_on_d phase_d] prech2_d d_and_model2
.model d_and_model2 d_and (rise_delay=0.1n fall_delay=0.1n input_load=1e-15)
A_dac_prech2 [prech2_d] [prech2_a] dac1

** ========================================================
** ANALOG SIGNAL CHAIN — ARRAY 1 (Layer 1: OR + NAND)
** ========================================================

** WL Drivers for Array 1 (4x, level shift 1.8V → 3.3V)
x_wld1_0 wl_in0 wl1_0 vdd vwl_pwr 0 wl_driver
x_wld1_1 wl_in1 wl1_1 vdd vwl_pwr 0 wl_driver
x_wld1_2 wl_in2 wl1_2 vdd vwl_pwr 0 wl_driver
x_wld1_3 wl_in3 wl1_3 vdd vwl_pwr 0 wl_driver

** BL Precharge for Array 1 (release during Phase 0 only)
XMP_pre1_0 a1_bl0 prech1_a vdd vdd sky130_fd_pr__pfet_01v8 L=0.15 W=2 nf=1
+ ad=0.58 as=0.58 pd=4.58 ps=4.58
XMP_pre1_1 a1_bl1 prech1_a vdd vdd sky130_fd_pr__pfet_01v8 L=0.15 W=2 nf=1
+ ad=0.58 as=0.58 pd=4.58 ps=4.58
XMP_pre1_2 a1_bl2 prech1_a vdd vdd sky130_fd_pr__pfet_01v8 L=0.15 W=2 nf=1
+ ad=0.58 as=0.58 pd=4.58 ps=4.58
XMP_pre1_3 a1_bl3 prech1_a vdd vdd sky130_fd_pr__pfet_01v8 L=0.15 W=2 nf=1
+ ad=0.58 as=0.58 pd=4.58 ps=4.58

** BL Parasitic Capacitance (5pF — ensures BL > 0.6V even with all rows active)
C_a1_bl0 a1_bl0 0 5p
C_a1_bl1 a1_bl1 0 5p
C_a1_bl2 a1_bl2 0 5p
C_a1_bl3 a1_bl3 0 5p

** SL Ground Switches for Array 1 (NFET: SL → GND when sl_en high)
XMN_sl1_0 a1_sl0 sl1_en0 0 0 sky130_fd_pr__nfet_01v8 L=0.15 W=10 nf=1
+ ad=2.9 as=2.9 pd=20.58 ps=20.58
XMN_sl1_1 a1_sl1 sl1_en1 0 0 sky130_fd_pr__nfet_01v8 L=0.15 W=10 nf=1
+ ad=2.9 as=2.9 pd=20.58 ps=20.58
XMN_sl1_2 a1_sl2 sl1_en2 0 0 sky130_fd_pr__nfet_01v8 L=0.15 W=10 nf=1
+ ad=2.9 as=2.9 pd=20.58 ps=20.58
XMN_sl1_3 a1_sl3 sl1_en3 0 0 sky130_fd_pr__nfet_01v8 L=0.15 W=10 nf=1
+ ad=2.9 as=2.9 pd=20.58 ps=20.58

** BL Write Drivers for Array 1 (disabled: EN=0, DATA=0)
** BL Write Drivers for Array 1 (disabled: EN=0, DATA=0)
** EN and DATA tied to VSS directly
x_blw1_0 0 0 a1_bl0 vdd 0 bl_write_driver
x_blw1_1 0 0 a1_bl1 vdd 0 bl_write_driver
x_blw1_2 0 0 a1_bl2 vdd 0 bl_write_driver
x_blw1_3 0 0 a1_bl3 vdd 0 bl_write_driver

** RRAM 4x4 Array 1
x_rram1 a1_bl0 a1_bl1 a1_bl2 a1_bl3 wl1_0 wl1_1 wl1_2 wl1_3
+        a1_sl0 a1_sl1 a1_sl2 a1_sl3 0 rram_array_1

** Sense Amplifiers for Array 1
** SA1: BL[0] vs BL[1] → OR result
x_sa1 sae_a a1_bl0 a1_bl1 sa1_q_a sa1_qb_a vdd 0 sense_amp
** SA2: BL[2] vs BL[3] → NAND result
x_sa2 sae_a a1_bl2 a1_bl3 sa2_q_a sa2_qb_a vdd 0 sense_amp

** ========================================================
** ANALOG SIGNAL CHAIN — ARRAY 2 (Layer 2: AND)
** ========================================================

** WL Drivers for Array 2 (4x, same wl_in signals)
x_wld2_0 wl_in0 wl2_0 vdd vwl_pwr 0 wl_driver
x_wld2_1 wl_in1 wl2_1 vdd vwl_pwr 0 wl_driver
x_wld2_2 wl_in2 wl2_2 vdd vwl_pwr 0 wl_driver
x_wld2_3 wl_in3 wl2_3 vdd vwl_pwr 0 wl_driver

** BL Precharge for Array 2 (release during Phase 1 only)
XMP_pre2_0 a2_bl0 prech2_a vdd vdd sky130_fd_pr__pfet_01v8 L=0.15 W=2 nf=1
+ ad=0.58 as=0.58 pd=4.58 ps=4.58
XMP_pre2_1 a2_bl1 prech2_a vdd vdd sky130_fd_pr__pfet_01v8 L=0.15 W=2 nf=1
+ ad=0.58 as=0.58 pd=4.58 ps=4.58
XMP_pre2_2 a2_bl2 prech2_a vdd vdd sky130_fd_pr__pfet_01v8 L=0.15 W=2 nf=1
+ ad=0.58 as=0.58 pd=4.58 ps=4.58
XMP_pre2_3 a2_bl3 prech2_a vdd vdd sky130_fd_pr__pfet_01v8 L=0.15 W=2 nf=1
+ ad=0.58 as=0.58 pd=4.58 ps=4.58

** BL Parasitic Capacitance (5pF)
C_a2_bl0 a2_bl0 0 5p
C_a2_bl1 a2_bl1 0 5p
C_a2_bl2 a2_bl2 0 5p
C_a2_bl3 a2_bl3 0 5p

** SL Ground Switches for Array 2
XMN_sl2_0 a2_sl0 sl2_en0 0 0 sky130_fd_pr__nfet_01v8 L=0.15 W=10 nf=1
+ ad=2.9 as=2.9 pd=20.58 ps=20.58
XMN_sl2_1 a2_sl1 sl2_en1 0 0 sky130_fd_pr__nfet_01v8 L=0.15 W=10 nf=1
+ ad=2.9 as=2.9 pd=20.58 ps=20.58
XMN_sl2_2 a2_sl2 sl2_en2 0 0 sky130_fd_pr__nfet_01v8 L=0.15 W=10 nf=1
+ ad=2.9 as=2.9 pd=20.58 ps=20.58
XMN_sl2_3 a2_sl3 sl2_en3 0 0 sky130_fd_pr__nfet_01v8 L=0.15 W=10 nf=1
+ ad=2.9 as=2.9 pd=20.58 ps=20.58

** BL Write Drivers for Array 2 (disabled)
** BL Write Drivers for Array 2 (disabled: EN=0, DATA=0)
x_blw2_0 0 0 a2_bl0 vdd 0 bl_write_driver
x_blw2_1 0 0 a2_bl1 vdd 0 bl_write_driver
x_blw2_2 0 0 a2_bl2 vdd 0 bl_write_driver
x_blw2_3 0 0 a2_bl3 vdd 0 bl_write_driver

** RRAM 4x4 Array 2
x_rram2 a2_bl0 a2_bl1 a2_bl2 a2_bl3 wl2_0 wl2_1 wl2_2 wl2_3
+        a2_sl0 a2_sl1 a2_sl2 a2_sl3 0 rram_array_2

** Sense Amplifier for Array 2
** SA3: BL[0] vs BL[1] → AND result = XOR
x_sa3 sae_a a2_bl0 a2_bl1 sa3_q_a sa3_qb_a vdd 0 sense_amp

** ========================================================
** SIMULATION CONTROL
** ========================================================
.control
pre_osdi $PDK_ROOT/sky130B/libs.tech/ngspice/sky130_fd_pr_reram__reram_module.osdi
save all
tran 1n 8000n

echo ""
echo "=============================================="
echo "XOR Inference Mixed-Signal Co-Simulation"
echo "=============================================="
echo ""

* Test 1: A=0, B=0 → expect XOR=0 (result ~200ns after start at 100ns)
echo "--- Test 1: A=0, B=0 → expect XOR=0 ---"
meas tran rv1_t WHEN v(rv_a)=0.9 RISE=1
meas tran xr1 FIND v(xr_a) WHEN v(rv_a)=0.9 RISE=1
meas tran sa1_t1 MAX v(sae_a) FROM=100n TO=500n

echo ""
* Test 2: A=0, B=1 → expect XOR=1
echo "--- Test 2: A=0, B=1 → expect XOR=1 ---"
meas tran rv2_t WHEN v(rv_a)=0.9 RISE=2
meas tran xr2 FIND v(xr_a) WHEN v(rv_a)=0.9 RISE=2

echo ""
* Test 3: A=1, B=0 → expect XOR=1
echo "--- Test 3: A=1, B=0 → expect XOR=1 ---"
meas tran rv3_t WHEN v(rv_a)=0.9 RISE=3
meas tran xr3 FIND v(xr_a) WHEN v(rv_a)=0.9 RISE=3

echo ""
* Test 4: A=1, B=1 → expect XOR=0
echo "--- Test 4: A=1, B=1 → expect XOR=0 ---"
meas tran rv4_t WHEN v(rv_a)=0.9 RISE=4
meas tran xr4 FIND v(xr_a) WHEN v(rv_a)=0.9 RISE=4

echo ""
echo "=============================================="

* Save CSV for plotting
wrdata xor_cosim.csv
+ v(rdy_a) v(rv_a) v(xr_a) v(phase_a) v(sae_a) v(start_a)
+ v(wl_in0) v(wl_in1)
+ v(a1_bl0) v(a1_bl1) v(a1_bl2) v(a1_bl3)
+ v(sa1_q_a) v(sa2_q_a)
+ v(a2_bl0) v(a2_bl1)
+ v(sa3_q_a)
+ v(sl1_en0) v(sl1_en1) v(sl2_en0) v(sl2_en1)
+ v(ia_a) v(ib_a)
+ v(prech1_a) v(prech2_a)

.endc
.end
