* Sense Amplifier Testbench
* StrongARM Latch-type SA - transient verification
* Small differential input -> full-swing output

.lib "$PDK_ROOT/sky130B/libs.tech/ngspice/sky130.lib.spice" tt

** Sense Amplifier Subcircuit **
.subckt sense_amp SAE INP INN Q QB VDD VSS
XMP3 Q SAE VDD VDD sky130_fd_pr__pfet_01v8 L=0.15 W=0.5 nf=1 mult=1
XMP4 QB SAE VDD VDD sky130_fd_pr__pfet_01v8 L=0.15 W=0.5 nf=1 mult=1
XMP5 QB SAE Q VDD sky130_fd_pr__pfet_01v8 L=0.15 W=0.5 nf=1 mult=1
XMP1 Q QB VDD VDD sky130_fd_pr__pfet_01v8 L=0.15 W=1 nf=1 mult=1
XMP2 QB Q VDD VDD sky130_fd_pr__pfet_01v8 L=0.15 W=1 nf=1 mult=1
XMN1 Q QB FN1 VSS sky130_fd_pr__nfet_01v8 L=0.15 W=1 nf=1 mult=1
XMN2 QB Q FN2 VSS sky130_fd_pr__nfet_01v8 L=0.15 W=1 nf=1 mult=1
XMN3 FN1 INP TAIL VSS sky130_fd_pr__nfet_01v8 L=0.15 W=2 nf=1 mult=1
XMN4 FN2 INN TAIL VSS sky130_fd_pr__nfet_01v8 L=0.15 W=2 nf=1 mult=1
XMN0 TAIL SAE VSS VSS sky130_fd_pr__nfet_01v8 L=0.15 W=2 nf=1 mult=1
.ends sense_amp

** Testbench **

* Power
VDD vdd 0 1.8
VSS vss 0 0

* SAE: precharge(0) for 10ns, then evaluate(1.8V)
*   period=40ns, precharge=20ns, evaluate=20ns
VSAE sae 0 PULSE(0 1.8 10n 0.1n 0.1n 19.8n 40n)

* Input: small differential (50mV difference)
* INP = 0.925V, INN = 0.875V (BL voltage ~ 0.9V +/- 25mV)
VINP inp 0 0.925
VINN inn 0 0.875

* Instantiate SA
X1 sae inp inn q qb vdd vss sense_amp

* Load capacitance on outputs (typical wire + gate load)
CQ q 0 10f
CQB qb 0 10f

* Simulation
.tran 0.01n 100n

* Control
.control
run

* Save waveform data
wrdata $PROJECT_ROOT/analog/sim/sa_result.csv v(sae) v(q) v(qb) v(inp) v(inn)

* Print key measurements
meas tran vq_final FIND v(q) AT=28n
meas tran vqb_final FIND v(qb) AT=28n
meas tran vq_precharge FIND v(q) AT=9n
meas tran vqb_precharge FIND v(qb) AT=9n

* Measure resolve time (Q falling from VDD to 0.9V)
meas tran t_sae_rise WHEN v(sae)=0.9 RISE=1
meas tran t_q_fall WHEN v(q)=0.9 FALL=1
meas tran t_resolve PARAM='t_q_fall - t_sae_rise'

echo "============================================"
echo "Sense Amplifier Simulation Results"
echo "============================================"
echo "Input: INP=0.925V, INN=0.875V (dV=50mV)"
echo "============================================"

quit
.endc

.end
